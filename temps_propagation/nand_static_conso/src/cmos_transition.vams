// Un générateur de transition CMOS
// Ce module récupère un signal logique (din) et génère des transitions
// de type CMOS dont le temps de transition est fourni par la variable wreal.
// Son principe est le suivant
// La fonction de transfert d'un inverseur CMOS de la technologie NANGATE a ete tabulée
// dans les deux tables tt_tablex, et tt_tabley. Ces tables ont été obtenues par simulation.
// Dans une première étape on génére un signal trapezoidal grace à la fonction "transition"
// Page 69 de la norme
// transition ( expr [ , td [ , rise_time [ , fall_time [ , time_tol ] ] ] ] )
// Chaque variation croissante ou décroissante de din provoque la génération d'une transition
// de retard td null,  et dont le temps de transition est ajusté. Le facteur "alpha_threshold" est
// utilisé pour tenir compte du gain de la fonction de transfert de mos.
// Enfin le signal trapezoidal sert d'indice pour la fonction mos tabulée à travers la fonction
// systeme $table_model.

// On utilise 1fs dans le timescale pour que les mesures de temps dans le domaine "numérique" soient précises.
// (YM : à confirmer, voir l'impact réel)
`timescale 1ns/1fs

// Pour AMS
`include "constants.vams"
`include "disciplines.vams"

module cmos_transition(
                      input wire din,   // Signal déclancheur de la transition
                      output electrical dout, // Le signal "réaliste en sortie
                      input wreal tt_val // temps de transition désiré
                      ) ;

// Les paramètres de caractérisation (pourcentages de la pleine excursion)
// homothetic parameter for gain cmos gain compensation
parameter real alpha_threshold = 21.76097456;

// Noms et valeurs issus du fichier au format "Liberty"
parameter real  slew_lower_threshold_pct 	= 0.3 ; // fraction de la pleine excursion
parameter real  slew_upper_threshold_pct 	= 0.7 ; // fraction de la pleine excursion
// Paramètre de tension récupéré du fichier de commande
parameter real  alim_voltage = $param("valim") ; // volts

// fonction de transfert de la logique CMOS exprimée en fraction de la pleine échelle
parameter real tt_tablex[0:478] = {0.0,
                                  0.19873047,
                                  0.22705078,
                                  0.24438477,
                                  0.25732422,
                                  0.26782227,
                                  0.27661133,
                                  0.28442383,
                                  0.29125977,
                                  0.29760742,
                                  0.30322266,
                                  0.30859375,
                                  0.31347656,
                                  0.31811523,
                                  0.32250977,
                                  0.32666016,
                                  0.33056641,
                                  0.33447266,
                                  0.33813477,
                                  0.34179688,
                                  0.34521484,
                                  0.34838867,
                                  0.35156250,
                                  0.35473633,
                                  0.35766602,
                                  0.36059570,
                                  0.36352539,
                                  0.36621094,
                                  0.36889648,
                                  0.37158203,
                                  0.37402344,
                                  0.37646484,
                                  0.37890625,
                                  0.38134766,
                                  0.38354492,
                                  0.38574219,
                                  0.38793945,
                                  0.39013672,
                                  0.39233398,
                                  0.39453125,
                                  0.39648438,
                                  0.39843750,
                                  0.40039062,
                                  0.40234375,
                                  0.40429688,
                                  0.40625000,
                                  0.40795898,
                                  0.40966797,
                                  0.41137695,
                                  0.41308594,
                                  0.41479492,
                                  0.41650391,
                                  0.41821289,
                                  0.41992188,
                                  0.42138672,
                                  0.42285156,
                                  0.42431641,
                                  0.42578125,
                                  0.42724609,
                                  0.42871094,
                                  0.43017578,
                                  0.43164062,
                                  0.43310547,
                                  0.43457031,
                                  0.43579102,
                                  0.43701172,
                                  0.43823242,
                                  0.43945312,
                                  0.44067383,
                                  0.44189453,
                                  0.44311523,
                                  0.44433594,
                                  0.44555664,
                                  0.44677734,
                                  0.44799805,
                                  0.44921875,
                                  0.45019531,
                                  0.45117188,
                                  0.45214844,
                                  0.45312500,
                                  0.45410156,
                                  0.45507812,
                                  0.45605469,
                                  0.45703125,
                                  0.45800781,
                                  0.45898438,
                                  0.45996094,
                                  0.46093750,
                                  0.46191406,
                                  0.46289062,
                                  0.46386719,
                                  0.46484375,
                                  0.46557617,
                                  0.46630859,
                                  0.46704102,
                                  0.46777344,
                                  0.46850586,
                                  0.46923828,
                                  0.46997070,
                                  0.47070312,
                                  0.47143555,
                                  0.47216797,
                                  0.47290039,
                                  0.47363281,
                                  0.47436523,
                                  0.47509766,
                                  0.47583008,
                                  0.47656250,
                                  0.47729492,
                                  0.47802734,
                                  0.47875977,
                                  0.47924805,
                                  0.47973633,
                                  0.48022461,
                                  0.48071289,
                                  0.48120117,
                                  0.48168945,
                                  0.48217773,
                                  0.48266602,
                                  0.48315430,
                                  0.48364258,
                                  0.48413086,
                                  0.48461914,
                                  0.48510742,
                                  0.48559570,
                                  0.48608398,
                                  0.48657227,
                                  0.48706055,
                                  0.48754883,
                                  0.48803711,
                                  0.48852539,
                                  0.48901367,
                                  0.48950195,
                                  0.48999023,
                                  0.49047852,
                                  0.49096680,
                                  0.49145508,
                                  0.49194336,
                                  0.49218750,
                                  0.49243164,
                                  0.49267578,
                                  0.49291992,
                                  0.49316406,
                                  0.49340820,
                                  0.49365234,
                                  0.49389648,
                                  0.49414062,
                                  0.49438477,
                                  0.49462891,
                                  0.49487305,
                                  0.49511719,
                                  0.49536133,
                                  0.49560547,
                                  0.49584961,
                                  0.49609375,
                                  0.49633789,
                                  0.49658203,
                                  0.49682617,
                                  0.49707031,
                                  0.49731445,
                                  0.49755859,
                                  0.49780273,
                                  0.49804688,
                                  0.49829102,
                                  0.49853516,
                                  0.49877930,
                                  0.49902344,
                                  0.49926758,
                                  0.49951172,
                                  0.49975586,
                                  0.50000000,
                                  0.50024414,
                                  0.50048828,
                                  0.50073242,
                                  0.50097656,
                                  0.50122070,
                                  0.50146484,
                                  0.50170898,
                                  0.50195312,
                                  0.50219727,
                                  0.50244141,
                                  0.50268555,
                                  0.50292969,
                                  0.50317383,
                                  0.50341797,
                                  0.50366211,
                                  0.50390625,
                                  0.50415039,
                                  0.50439453,
                                  0.50463867,
                                  0.50488281,
                                  0.50512695,
                                  0.50537109,
                                  0.50561523,
                                  0.50585938,
                                  0.50610352,
                                  0.50634766,
                                  0.50659180,
                                  0.50683594,
                                  0.50708008,
                                  0.50732422,
                                  0.50756836,
                                  0.50781250,
                                  0.50805664,
                                  0.50830078,
                                  0.50854492,
                                  0.50878906,
                                  0.50903320,
                                  0.50927734,
                                  0.50952148,
                                  0.50976562,
                                  0.51000977,
                                  0.51025391,
                                  0.51049805,
                                  0.51074219,
                                  0.51098633,
                                  0.51123047,
                                  0.51147461,
                                  0.51171875,
                                  0.51196289,
                                  0.51220703,
                                  0.51245117,
                                  0.51269531,
                                  0.51293945,
                                  0.51318359,
                                  0.51342773,
                                  0.51367188,
                                  0.51391602,
                                  0.51416016,
                                  0.51440430,
                                  0.51464844,
                                  0.51489258,
                                  0.51513672,
                                  0.51538086,
                                  0.51562500,
                                  0.51586914,
                                  0.51611328,
                                  0.51635742,
                                  0.51660156,
                                  0.51684570,
                                  0.51708984,
                                  0.51733398,
                                  0.51757812,
                                  0.51782227,
                                  0.51806641,
                                  0.51831055,
                                  0.51855469,
                                  0.51879883,
                                  0.51904297,
                                  0.51928711,
                                  0.51953125,
                                  0.51977539,
                                  0.52001953,
                                  0.52026367,
                                  0.52050781,
                                  0.52075195,
                                  0.52099609,
                                  0.52124023,
                                  0.52148438,
                                  0.52172852,
                                  0.52197266,
                                  0.52221680,
                                  0.52246094,
                                  0.52270508,
                                  0.52294922,
                                  0.52319336,
                                  0.52343750,
                                  0.52368164,
                                  0.52392578,
                                  0.52416992,
                                  0.52441406,
                                  0.52465820,
                                  0.52490234,
                                  0.52514648,
                                  0.52539062,
                                  0.52563477,
                                  0.52587891,
                                  0.52612305,
                                  0.52636719,
                                  0.52661133,
                                  0.52685547,
                                  0.52709961,
                                  0.52734375,
                                  0.52758789,
                                  0.52783203,
                                  0.52807617,
                                  0.52832031,
                                  0.52856445,
                                  0.52880859,
                                  0.52905273,
                                  0.52929688,
                                  0.52954102,
                                  0.52978516,
                                  0.53002930,
                                  0.53027344,
                                  0.53051758,
                                  0.53076172,
                                  0.53100586,
                                  0.53125000,
                                  0.53149414,
                                  0.53173828,
                                  0.53198242,
                                  0.53222656,
                                  0.53247070,
                                  0.53271484,
                                  0.53295898,
                                  0.53320312,
                                  0.53344727,
                                  0.53369141,
                                  0.53393555,
                                  0.53417969,
                                  0.53442383,
                                  0.53466797,
                                  0.53491211,
                                  0.53515625,
                                  0.53540039,
                                  0.53564453,
                                  0.53588867,
                                  0.53613281,
                                  0.53637695,
                                  0.53662109,
                                  0.53686523,
                                  0.53710938,
                                  0.53735352,
                                  0.53759766,
                                  0.53784180,
                                  0.53808594,
                                  0.53833008,
                                  0.53857422,
                                  0.53881836,
                                  0.53906250,
                                  0.53930664,
                                  0.53955078,
                                  0.54003906,
                                  0.54052734,
                                  0.54101562,
                                  0.54150391,
                                  0.54199219,
                                  0.54248047,
                                  0.54296875,
                                  0.54345703,
                                  0.54394531,
                                  0.54443359,
                                  0.54492188,
                                  0.54541016,
                                  0.54589844,
                                  0.54638672,
                                  0.54687500,
                                  0.54736328,
                                  0.54785156,
                                  0.54833984,
                                  0.54882812,
                                  0.54931641,
                                  0.54980469,
                                  0.55029297,
                                  0.55078125,
                                  0.55126953,
                                  0.55175781,
                                  0.55224609,
                                  0.55273438,
                                  0.55322266,
                                  0.55371094,
                                  0.55419922,
                                  0.55468750,
                                  0.55517578,
                                  0.55566406,
                                  0.55615234,
                                  0.55664062,
                                  0.55712891,
                                  0.55786133,
                                  0.55859375,
                                  0.55932617,
                                  0.56005859,
                                  0.56079102,
                                  0.56152344,
                                  0.56225586,
                                  0.56298828,
                                  0.56372070,
                                  0.56445312,
                                  0.56518555,
                                  0.56591797,
                                  0.56665039,
                                  0.56738281,
                                  0.56811523,
                                  0.56884766,
                                  0.56958008,
                                  0.57031250,
                                  0.57104492,
                                  0.57177734,
                                  0.57250977,
                                  0.57324219,
                                  0.57397461,
                                  0.57470703,
                                  0.57543945,
                                  0.57617188,
                                  0.57714844,
                                  0.57812500,
                                  0.57910156,
                                  0.58007812,
                                  0.58105469,
                                  0.58203125,
                                  0.58300781,
                                  0.58398438,
                                  0.58496094,
                                  0.58593750,
                                  0.58691406,
                                  0.58789062,
                                  0.58886719,
                                  0.58984375,
                                  0.59082031,
                                  0.59179688,
                                  0.59277344,
                                  0.59375000,
                                  0.59497070,
                                  0.59619141,
                                  0.59741211,
                                  0.59863281,
                                  0.59985352,
                                  0.60107422,
                                  0.60229492,
                                  0.60351562,
                                  0.60473633,
                                  0.60595703,
                                  0.60717773,
                                  0.60839844,
                                  0.60961914,
                                  0.61108398,
                                  0.61254883,
                                  0.61401367,
                                  0.61547852,
                                  0.61694336,
                                  0.61840820,
                                  0.61987305,
                                  0.62133789,
                                  0.62280273,
                                  0.62426758,
                                  0.62597656,
                                  0.62768555,
                                  0.62939453,
                                  0.63110352,
                                  0.63281250,
                                  0.63452148,
                                  0.63623047,
                                  0.63818359,
                                  0.64013672,
                                  0.64208984,
                                  0.64404297,
                                  0.64599609,
                                  0.64794922,
                                  0.65014648,
                                  0.65234375,
                                  0.65454102,
                                  0.65673828,
                                  0.65917969,
                                  0.66162109,
                                  0.66406250,
                                  0.66674805,
                                  0.66943359,
                                  0.67211914,
                                  0.67504883,
                                  0.67797852,
                                  0.68115234,
                                  0.68457031,
                                  0.68798828,
                                  0.69165039,
                                  0.69555664,
                                  0.69970703,
                                  0.70410156,
                                  0.70898438,
                                  0.71411133,
                                  0.71972656,
                                  0.72607422,
                                  0.73315430,
                                  0.74145508,
                                  0.75146484,
                                  0.76416016,
                                  0.78173828,
                                  0.81225586,
                                  1.0};

parameter real tt_tabley[0:478] = {0.0,
                                  0.00100404,
                                  0.00201187,
                                  0.00301529,
                                  0.00402559,
                                  0.00504661,
                                  0.00605761,
                                  0.00708798,
                                  0.00810007,
                                  0.00913860,
                                  0.01014055,
                                  0.01117319,
                                  0.01218047,
                                  0.01319657,
                                  0.01421583,
                                  0.01523114,
                                  0.01623378,
                                  0.01728333,
                                  0.01831201,
                                  0.01938175,
                                  0.02042108,
                                  0.02142259,
                                  0.02245653,
                                  0.02352825,
                                  0.02454866,
                                  0.02560066,
                                  0.02668498,
                                  0.02770682,
                                  0.02875938,
                                  0.02983871,
                                  0.03084680,
                                  0.03188008,
                                  0.03293915,
                                  0.03402535,
                                  0.03502547,
                                  0.03604809,
                                  0.03709377,
                                  0.03816234,
                                  0.03925593,
                                  0.04037449,
                                  0.04139030,
                                  0.04242694,
                                  0.04348497,
                                  0.04456499,
                                  0.04566765,
                                  0.04679362,
                                  0.04779853,
                                  0.04882235,
                                  0.04986562,
                                  0.05092891,
                                  0.05201283,
                                  0.05311801,
                                  0.05424513,
                                  0.05539492,
                                  0.05639906,
                                  0.05742092,
                                  0.05846103,
                                  0.05951996,
                                  0.06059831,
                                  0.06169670,
                                  0.06281582,
                                  0.06395636,
                                  0.06511907,
                                  0.06630474,
                                  0.06731094,
                                  0.06833421,
                                  0.06937509,
                                  0.07043418,
                                  0.07151203,
                                  0.07260931,
                                  0.07372667,
                                  0.07486496,
                                  0.07602472,
                                  0.07720696,
                                  0.07841247,
                                  0.07964217,
                                  0.08064401,
                                  0.08166249,
                                  0.08269822,
                                  0.08375170,
                                  0.08482360,
                                  0.08591459,
                                  0.08702537,
                                  0.08815667,
                                  0.08930930,
                                  0.09048410,
                                  0.09168195,
                                  0.09290382,
                                  0.09415076,
                                  0.09542377,
                                  0.09672414,
                                  0.09805305,
                                  0.09906939,
                                  0.10010306,
                                  0.10115463,
                                  0.10222530,
                                  0.10331516,
                                  0.10442553,
                                  0.10555673,
                                  0.10670997,
                                  0.10788614,
                                  0.10908621,
                                  0.11031142,
                                  0.11156238,
                                  0.11284086,
                                  0.11414822,
                                  0.11548535,
                                  0.11685443,
                                  0.11825671,
                                  0.11969402,
                                  0.12116856,
                                  0.12217338,
                                  0.12319631,
                                  0.12423814,
                                  0.12529964,
                                  0.12638165,
                                  0.12748503,
                                  0.12861083,
                                  0.12975995,
                                  0.13093356,
                                  0.13213275,
                                  0.13335882,
                                  0.13461310,
                                  0.13589706,
                                  0.13721152,
                                  0.13856048,
                                  0.13994343,
                                  0.14136321,
                                  0.14282197,
                                  0.14432211,
                                  0.14586622,
                                  0.14745713,
                                  0.14909796,
                                  0.15079213,
                                  0.15254343,
                                  0.15435600,
                                  0.15623470,
                                  0.15818413,
                                  0.15918722,
                                  0.16021022,
                                  0.16125395,
                                  0.16231926,
                                  0.16340704,
                                  0.16451825,
                                  0.16565389,
                                  0.16681503,
                                  0.16800278,
                                  0.16921834,
                                  0.17046295,
                                  0.17173795,
                                  0.17304473,
                                  0.17438478,
                                  0.17575966,
                                  0.17717103,
                                  0.17862064,
                                  0.18011033,
                                  0.18164205,
                                  0.18321784,
                                  0.18483986,
                                  0.18651037,
                                  0.18823174,
                                  0.19000645,
                                  0.19183710,
                                  0.19372638,
                                  0.19567708,
                                  0.19769210,
                                  0.19977441,
                                  0.20192707,
                                  0.20415317,
                                  0.20645586,
                                  0.20883831,
                                  0.21130364,
                                  0.21385497,
                                  0.21649531,
                                  0.21922759,
                                  0.22205456,
                                  0.22497878,
                                  0.22800258,
                                  0.23112801,
                                  0.23435680,
                                  0.23769032,
                                  0.24112956,
                                  0.24467509,
                                  0.24832707,
                                  0.25208519,
                                  0.25594873,
                                  0.25991651,
                                  0.26398695,
                                  0.26815808,
                                  0.27242756,
                                  0.27679272,
                                  0.28125062,
                                  0.28579807,
                                  0.29043169,
                                  0.29514794,
                                  0.29994316,
                                  0.30481364,
                                  0.30975562,
                                  0.31476534,
                                  0.31983907,
                                  0.32497246,
                                  0.33016337,
                                  0.33540731,
                                  0.34070105,
                                  0.34604123,
                                  0.35142467,
                                  0.35684828,
                                  0.36230911,
                                  0.36780433,
                                  0.37333123,
                                  0.37888721,
                                  0.38446979,
                                  0.39007659,
                                  0.39570537,
                                  0.40135393,
                                  0.40702022,
                                  0.41270223,
                                  0.41839807,
                                  0.42410589,
                                  0.42982392,
                                  0.43555047,
                                  0.44128388,
                                  0.44702256,
                                  0.45276495,
                                  0.45850953,
                                  0.46425484,
                                  0.46999941,
                                  0.47574182,
                                  0.48148067,
                                  0.48721457,
                                  0.49294213,
                                  0.49866199,
                                  0.50437277,
                                  0.51007311,
                                  0.51576162,
                                  0.52143692,
                                  0.52709761,
                                  0.53274229,
                                  0.53836950,
                                  0.54397781,
                                  0.54956571,
                                  0.55513171,
                                  0.56067425,
                                  0.56619176,
                                  0.57168261,
                                  0.57714514,
                                  0.58257766,
                                  0.58797841,
                                  0.59334559,
                                  0.59867738,
                                  0.60397187,
                                  0.60922713,
                                  0.61444116,
                                  0.61961194,
                                  0.62473737,
                                  0.62981534,
                                  0.63484367,
                                  0.63982017,
                                  0.64474260,
                                  0.64960871,
                                  0.65441624,
                                  0.65916291,
                                  0.66384645,
                                  0.66846463,
                                  0.67301522,
                                  0.67749606,
                                  0.68190505,
                                  0.68624017,
                                  0.69049951,
                                  0.69468126,
                                  0.69878376,
                                  0.70280550,
                                  0.70674515,
                                  0.71060156,
                                  0.71437379,
                                  0.71806111,
                                  0.72166301,
                                  0.72517923,
                                  0.72860973,
                                  0.73195472,
                                  0.73521461,
                                  0.73839008,
                                  0.74148200,
                                  0.74449145,
                                  0.74741971,
                                  0.75026822,
                                  0.75303857,
                                  0.75573251,
                                  0.75835189,
                                  0.76089867,
                                  0.76337486,
                                  0.76578257,
                                  0.76812390,
                                  0.77040103,
                                  0.77261610,
                                  0.77477128,
                                  0.77686871,
                                  0.77891049,
                                  0.78089871,
                                  0.78283540,
                                  0.78472254,
                                  0.78656206,
                                  0.78835583,
                                  0.79010565,
                                  0.79181327,
                                  0.79348037,
                                  0.79510856,
                                  0.79669939,
                                  0.79825434,
                                  0.79977484,
                                  0.80126224,
                                  0.80271784,
                                  0.80414288,
                                  0.80553855,
                                  0.80690597,
                                  0.80824622,
                                  0.80956052,
                                  0.81084935,
                                  0.81211397,
                                  0.81335544,
                                  0.81457419,
                                  0.81577138,
                                  0.81694762,
                                  0.81810367,
                                  0.81924022,
                                  0.82035795,
                                  0.82145748,
                                  0.82253942,
                                  0.82360436,
                                  0.82465283,
                                  0.82568537,
                                  0.82670249,
                                  0.82770465,
                                  0.82966597,
                                  0.83157275,
                                  0.83342817,
                                  0.83523512,
                                  0.83699625,
                                  0.83871402,
                                  0.84039069,
                                  0.84202833,
                                  0.84362889,
                                  0.84519415,
                                  0.84672577,
                                  0.84822530,
                                  0.84969416,
                                  0.85113371,
                                  0.85254519,
                                  0.85392976,
                                  0.85528853,
                                  0.85662253,
                                  0.85793272,
                                  0.85922000,
                                  0.86048523,
                                  0.86172921,
                                  0.86295270,
                                  0.86415642,
                                  0.86534104,
                                  0.86650720,
                                  0.86765552,
                                  0.86878656,
                                  0.86990088,
                                  0.87099899,
                                  0.87208138,
                                  0.87314854,
                                  0.87420090,
                                  0.87523889,
                                  0.87626292,
                                  0.87727338,
                                  0.87876443,
                                  0.88022697,
                                  0.88166211,
                                  0.88307089,
                                  0.88445429,
                                  0.88581323,
                                  0.88714858,
                                  0.88846117,
                                  0.88975176,
                                  0.89102109,
                                  0.89226985,
                                  0.89349870,
                                  0.89470826,
                                  0.89589912,
                                  0.89707184,
                                  0.89822695,
                                  0.89936497,
                                  0.90048638,
                                  0.90159167,
                                  0.90268122,
                                  0.90375549,
                                  0.90481488,
                                  0.90585977,
                                  0.90689054,
                                  0.90790754,
                                  0.90891110,
                                  0.91022886,
                                  0.91152404,
                                  0.91279736,
                                  0.91404947,
                                  0.91528100,
                                  0.91649254,
                                  0.91768467,
                                  0.91885793,
                                  0.92001283,
                                  0.92114986,
                                  0.92226950,
                                  0.92337219,
                                  0.92445836,
                                  0.92552842,
                                  0.92658276,
                                  0.92762176,
                                  0.92864578,
                                  0.92965517,
                                  0.93089682,
                                  0.93211674,
                                  0.93331552,
                                  0.93449372,
                                  0.93565187,
                                  0.93679048,
                                  0.93791004,
                                  0.93901101,
                                  0.94009383,
                                  0.94115892,
                                  0.94220670,
                                  0.94323755,
                                  0.94425184,
                                  0.94544763,
                                  0.94662069,
                                  0.94777156,
                                  0.94890078,
                                  0.95000886,
                                  0.95109629,
                                  0.95216353,
                                  0.95321103,
                                  0.95423920,
                                  0.95524845,
                                  0.95640253,
                                  0.95753198,
                                  0.95863736,
                                  0.95971921,
                                  0.96077805,
                                  0.96181436,
                                  0.96282861,
                                  0.96396131,
                                  0.96506643,
                                  0.96614458,
                                  0.96719634,
                                  0.96822226,
                                  0.96922290,
                                  0.97031902,
                                  0.97138448,
                                  0.97241997,
                                  0.97342613,
                                  0.97451045,
                                  0.97556016,
                                  0.97657605,
                                  0.97765541,
                                  0.97869578,
                                  0.97969821,
                                  0.98074943,
                                  0.98175770,
                                  0.98280285,
                                  0.98387518,
                                  0.98489357,
                                  0.98592685,
                                  0.98696534,
                                  0.98799968,
                                  0.98902072,
                                  0.99007011,
                                  0.99108076,
                                  0.99208711,
                                  0.99310696,
                                  0.99410913,
                                  0.99512028,
                                  0.99613313,
                                  0.99714413,
                                  0.99814728,
                                  0.99915209,
                                  1.0};
analog
begin
  V(dout) <+ alim_voltage*$table_model(transition(din,0,alpha_threshold*tt_val/(slew_upper_threshold_pct-slew_lower_threshold_pct)),tt_tablex,tt_tabley) ;
end

endmodule
