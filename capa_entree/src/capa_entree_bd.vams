// La maquette de test écrite en language Verilog-ams
// On prend 1fs dans le timescale pour que les mesures de temps dans le domaine "numérique" soient précises.
// (à confirmer)
`timescale 1ns/1fs

`include "constants.vams"
`include "disciplines.vams"
`include "cmos_transition.vams"

module input_capa_bd(
                        input wreal din,
			input wreal din_cst,
			input wreal tt_val,
			input wreal capa_charge_val,
			input wreal capa_test_val,
                        output wreal circuit_propagation_time,
                        output wreal test_propagation_time,
                        input wire fin_test
                         );

// Paramètre de tension récupéré du fichier de commande
parameter real  alim_voltage = $param("valim") ; // volts

// Les paramètres de caractérisation (pourcentages de la pleine excursion)
// Noms et valeurs issus du fichier au format "Liberty"
parameter real  slew_lower_threshold_pct 	= 0.3 ; // fraction de la pleine excursion
parameter real  slew_upper_threshold_pct 	= 0.7 ; // fraction de la pleine excursion
parameter real  input_threshold_pct      	= 0.5 ; // fraction de la pleine excursion
parameter real  output_threshold_pct      	= 0.5 ; // fraction de la pleine excursion

// Les signaux logiques et électriques
electrical din_real     ; // Signal electrique dérivé de din
electrical dout_buf1    ; // Signal electrique de sortie du buffer1
electrical dout_buf2    ; // Signal electrique de sortie du buffer2
electrical dout         ; // Signal electrique de sortie de l'additionneur

// Les références d'alimentation
electrical vss          ; // La référence de masse
ground vss              ; // C'est une référence globale associée au noeud "0" du simulateur électrique
electrical vdd_dut      ; // L'alimentation du dispositif à tester

branch (vdd_dut,vss) alimentation_dut     ; //  L'alimentation du dispositif à mesurer
branch (dout,vss) capa_charge         ; //  La capacité de charge en sortie
branch (dout_buf2,vss) capa_test         ; //  La capacité de charge en sortie

// Le circuit à tester
AND2_X4 and2 (.VDD(vdd_dut),.VSS(vss),.A1(din_cst),.A2(dout_buf1),.ZN(dout)) ;
BUF_X4 buffer1 (.VDD(vdd_dut),.VSS(vss),.A(din_real),.Z(dout_buf1));
BUF_X4 buffer2 (.VDD(vdd_dut),.VSS(vss),.A(din_real),.Z(dout_buf2));
// Le génrateur de transitions réalistes
cmos_transition cmos_tr(.din(din),.dout(din_real),.tt_val(tt_val)) ;

analog
begin
 // La source d'alimentation de la logique en test
 V(alimentation_dut) <+ alim_voltage ;
 // La capacité de charge en sortie, dont la valeur est réglée dans le testbench SystemVerilog
 I(capa_charge) <+ ddt(V(capa_charge))*capa_charge_val;
 I(capa_test) <+ ddt(V(capa_test))*capa_test_val;
 @(posedge fin_test)
   $finish ;
end

///////////////////////////////////////////////////////////////
// Le monde numérique
///////////////////////////////////////////////////////////////

real tmp_start_time      ;
real tmp_stop_time_circuit       ;
real tmp_stop_time_test       ;
always
 @(cross(V(din_real)-alim_voltage*input_threshold_pct, +1,1e-15,1e-4 ))
    tmp_start_time = $abstime ;
always
 @(cross(V(dout_buf1)-alim_voltage*output_threshold_pct, +1,1e-15,1e-4 ))
    tmp_stop_time_circuit = $abstime   ;
always
 @(cross(V(capa_test)-alim_voltage*output_threshold_pct, +1,1e-15,1e-4 ))
    tmp_stop_time_test = $abstime   ;
always
 @(cross(V(din_real)-alim_voltage*input_threshold_pct, -1,1e-15,1e-4 ))
    tmp_start_time = $abstime ;
always
 @(cross(V(dout_buf1)-alim_voltage*output_threshold_pct, -1,1e-15,1e-4 ))
    tmp_stop_time_circuit = $abstime   ;
always
 @(cross(V(capa_test)-alim_voltage*output_threshold_pct, -1,1e-15,1e-4 ))
    tmp_stop_time_test = $abstime   ;

// transmission des valeurs calculées vers le monde numérique
assign circuit_propagation_time = tmp_stop_time_circuit-tmp_start_time ;
assign test_propagation_time = tmp_stop_time_test-tmp_start_time ;

endmodule
